# Ansys Electronics Desktop project, version 2019.1
materials:
  vacuum: permittivity=1
  copper: permeability=0.999991 conductivity=58000000
  steel_stainless: conductivity=1100000
  polyamide: permittivity=4.3 dielectric_loss_tangent=0.004

design HFSSDesign2 (HFSS, DrivenModal, model units mm)
variables:
  a = 8mm
  r1 = 15.5mm
  r0 = 16mm
  fi = 10*pi
  l = 45mm
geometry:
  EquationCurve1 [copper] = equation_curve(x=r0*exp(a*_t)*cos(_t), y=r0*exp(a*_t)*sin(_t), z=0, _t=0 to fi)
  EquationCurve2 = equation_curve(x=r1*exp(a*_t)*cos(_t), y=r1*exp(a*_t)*sin(_t), z=0, _t=0 to fi)
  EquationCurve1.connect(EquationCurve2)
  Rectangle1 [polyamide] = rectangle(corner=(-l/2, -l/2, 0mm), x_size=l, y_size=l)
  Rectangle1.thicken(-0.07mm)
  EquationCurve1.thicken(0.01mm)
  Box1 [vacuum] = box(corner=(-160mm, -160mm, -80mm), size=(380mm, 400mm, 340mm))
  EquationCurve1.move(0mm, 0mm, -0.05mm)
  coordinate_system RelativeCS1 = origin=(38.571929mm, 0mm, -0.05mm) x=(1mm, 0mm, 0mm) y=(0mm, 1mm, 0mm)
  Rectangle2 = rectangle(corner=(15.2mm, -0.4mm, 0mm), x_size=5.6mm, y_size=0.8mm)
  Rectangle2.move(-0.0083043273mm, 0mm, -0.05mm)
  Cylinder1 [copper] = cylinder(axis=Z, base_centre=(20.3mm, 0mm, 0mm), radius=0.2mm, height=0.3mm)
  Rectangle3 = rectangle(corner=(15.191696mm, -0.4mm, -0.05mm), x_size=-0.33169567mm, y_size=0.8mm)
  Rectangle4 = rectangle(corner=(14.86mm, -0.4mm, -0.05mm), x_size=-0.48mm, y_size=0.8mm)
  Cylinder2 [copper] = cylinder(axis=Z, base_centre=(14.58mm, 0mm, 0mm), radius=0.2mm, height=0.3mm)
  Rectangle5 = rectangle(corner=(14.38mm, -0.4mm, 0.3mm), x_size=6.4116957mm, y_size=0.8mm)
boundaries and excitations:
  Rad1: Radiation Objects=Box1
  PerfE1: Perfect E Objects=Rectangle2
  PerfE2: Perfect E Objects=Rectangle3
  PerfE3: Perfect E Objects=Rectangle4
  1: Lumped Port Objects=Rectangle3 Modes{Mode1{IntLine{Rectangle3.vertex(4 of 4) -> Rectangle3.vertex(3 of 4)} CharImp=Zpi RenormImp=50ohm}} Impedance=50ohm
setups:
  Setup1: HfssDriven Frequency=1.5GHz MaxDeltaS=0.02 MaximumPasses=15 MinimumPasses=1 MinimumConvergedPasses=1 PercentRefinement=30 BasisOrder=1 PortAccuracy=2
    sweep Sweep: 1GHz to 2GHz, 451 points; Type=Fast SaveFields
source amplitudes:
  1:1: 1W 0deg
