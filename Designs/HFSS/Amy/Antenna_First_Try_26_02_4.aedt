# Ansys Electronics Desktop project, version 2019.1
materials:
  vacuum: permittivity=1
  copper: permeability=0.999991 conductivity=58000000

design HFSSDesign1 (HFSS, DrivenModal, model units mm)
options: Calculate_Lossy_Dielectrics
variables:
  fi = 10*pi
  a = 8mm
  r0 = 5mm
  r1 = 4.8mm
geometry:
  Box1 [vacuum] = box(corner=(-250mm, -250mm, -250mm), size=(500mm, 500mm, 500mm))
  EquationCurve1 = equation_curve(x=r0*exp(a*_t)*cos(_t), y=r0*exp(a*_t)*sin(_t), z=0, _t=0 to fi)
  EquationCurve2 = equation_curve(x=r1*exp(a*_t)*cos(_t), y=r1*exp(a*_t)*sin(_t), z=0, _t=0 to fi)
  EquationCurve1.connect(EquationCurve2)
  Cylinder1 [copper] = cylinder(axis=Z, base_centre=(6.3mm, 0mm, 0mm), radius=0.095859337mm, height=0.15mm)
  Rectangle1 = rectangle(corner=(5mm, 0.1mm, 0mm), x_size=-0.3mm, y_size=-0.2mm)
  Rectangle2 = rectangle(corner=(4.7mm, 0.1mm, 0mm), x_size=-0.3mm, y_size=-0.2mm)
  Rectangle3 = rectangle(corner=(4.4mm, 0.1mm, 0mm), x_size=-0.2mm, y_size=-0.2mm)
  Cylinder2 [copper] = cylinder(axis=Z, base_centre=(4.2mm, 0mm, 0mm), radius=0.1mm, height=0.15mm)
  Rectangle4 = rectangle(corner=(4mm, 0.1mm, 0.15mm), x_size=2.5mm, y_size=-0.2mm)
  [Cylinder1, Rectangle1, Rectangle2, Rectangle3, Cylinder2, Rectangle4].move(0mm, -0.1mm, 0mm)
boundaries and excitations:
  PerfE1: Perfect E Objects=EquationCurve1
  PerfE2: Perfect E Objects=[Rectangle1, Rectangle3, Rectangle4]
  1: Lumped Port Objects=Rectangle2 Modes{Mode1{IntLine{middle of Rectangle2.edge(x at corner) -> middle of Rectangle2.edge(x opposite corner)} CharImp=Zpi RenormImp=50ohm}} Impedance=50ohm
setups:
  Setup1: HfssDriven Frequency=1GHz MaxDeltaS=0.02 MaximumPasses=10 MinimumPasses=1 MinimumConvergedPasses=1 PercentRefinement=30 BasisOrder=1 PortAccuracy=2
    sweep Sweep: 0.8GHz to 2GHz, 451 points; Type=Fast
source amplitudes:
  1:1: 1W 0deg
reports:
  XY Plot 1: re(Z(1,1)) vs Freq on Setup1 : LastAdaptive
  XY Plot 2: im(Z(1,1)) vs Freq on Setup1 : LastAdaptive
  S Parameter Plot 1: dB(S(1,1)) vs Freq on Setup1 : Sweep; markers m1 at 11.888889MHz, m2 at 14.666667MHz
