# Ansys Electronics Desktop project, version 2019.1
materials:
  vacuum: permittivity=1
  copper: permeability=0.999991 conductivity=58000000

design HFSSDesign1 (HFSS, DrivenModal, model units mm)
options: Calculate_Lossy_Dielectrics
variables:
  fi = 5*2*pi
  a = 1mm
  r0 = 25mm
  r1 = 30mm
geometry:
  Box1 [vacuum] = box(corner=(-250mm, -250mm, -250mm), size=(500mm, 500mm, 500mm))
  EquationCurve1 = equation_curve(x=r0*exp(a*_t)*cos(_t), y=r0*exp(a*_t)*sin(_t), z=0, _t=0 to fi)
  EquationCurve2 = equation_curve(x=r1*exp(a*_t)*cos(_t), y=r1*exp(a*_t)*sin(_t), z=0, _t=0 to fi)
  EquationCurve1.connect(EquationCurve2)
  Cylinder1 [copper] = cylinder(axis=Z, base_centre=(r1, 0mm, 0mm), radius=0.095859337mm, height=0.15mm)
  Rectangle1 = rectangle(corner=(r1, 0.1mm, 0mm), x_size=-0.3mm, y_size=-0.2mm)
  Rectangle2 = rectangle(corner=(r1, 0.1mm, 0mm), x_size=-0.3mm, y_size=-0.2mm)
  Rectangle3 = rectangle(corner=(r0, 0.1mm, 0mm), x_size=-0.2mm, y_size=-0.2mm)
  Cylinder2 [copper] = cylinder(axis=Z, base_centre=(r0, 0mm, 0mm), radius=0.1mm, height=0.15mm)
  Rectangle4 = rectangle(corner=(r0, 0.1mm, 0.15mm), x_size=r1-r0, y_size=-0.2mm)
boundaries and excitations:
  PerfE1: Perfect E Objects=EquationCurve1
  PerfE2: Perfect E Objects=[Rectangle1, Rectangle3, Rectangle4]
  1: Lumped Port Objects=Rectangle2 Modes{Mode1{IntLine{middle of Rectangle2.edge(x at corner) -> middle of Rectangle2.edge(x opposite corner)} CharImp=Zpi RenormImp=50ohm}} Impedance=50ohm
setups:
  Setup1: HfssDriven Frequency=13.56MHz MaxDeltaS=0.02 MaximumPasses=10 MinimumPasses=1 MinimumConvergedPasses=1 PercentRefinement=30 BasisOrder=1 PortAccuracy=2
source amplitudes:
  1:1: 1W 0deg
reports:
  XY Plot 1: re(Z(1,1)) vs Freq on Setup1 : LastAdaptive
  XY Plot 2: im(Z(1,1)) vs Freq on Setup1 : LastAdaptive
