# Ansys Electronics Desktop project, version 2019.1
materials:
  vacuum: permittivity=1
  copper: permeability=0.999991 conductivity=58000000
  steel_stainless: conductivity=1100000
  polyamide: permittivity=4.3 dielectric_loss_tangent=0.004

design HFSSDesign2 (HFSS, DrivenModal, model units mm)
variables:
  a = 8mm
  r1 = 29mm
  r0 = 30mm
  fi = 10*pi
geometry:
  EquationCurve1 [copper] = equation_curve(x=r0*exp(a*_t)*cos(_t), y=r0*exp(a*_t)*sin(_t), z=0, _t=0 to fi)
  EquationCurve2 = equation_curve(x=r1*exp(a*_t)*cos(_t), y=r1*exp(a*_t)*sin(_t), z=0, _t=0 to fi)
  EquationCurve1.connect(EquationCurve2)
  Rectangle1 [polyamide] = rectangle(corner=(-40mm, -50mm, -0.05mm), x_size=90mm, y_size=100mm)
  Rectangle1.thicken(0.05mm)
  EquationCurve1.thicken(0.01mm)
  Box1 [vacuum] = box(corner=(-160mm, -160mm, -80mm), size=(380mm, 400mm, 340mm))
