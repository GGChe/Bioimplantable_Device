# Ansys Electronics Desktop project, version 2019.1
materials:
  vacuum: permittivity=1
  copper: permeability=0.999991 conductivity=58000000
  steel_stainless: conductivity=1100000
  polyamide: permittivity=4.3 dielectric_loss_tangent=0.004

design HFSSDesign2 (HFSS, DrivenModal, model units mm)
variables:
  a = 8mm
  r1 = 24mm
  r0 = 25mm
  fi = 10*pi
geometry:
  EquationCurve1 [copper] = equation_curve(x=r0*exp(a*_t)*cos(_t), y=r0*exp(a*_t)*sin(_t), z=0, _t=0 to fi)
  EquationCurve2 = equation_curve(x=r1*exp(a*_t)*cos(_t), y=r1*exp(a*_t)*sin(_t), z=0, _t=0 to fi)
  EquationCurve1.connect(EquationCurve2)
  Rectangle1 [polyamide] = rectangle(corner=(-40mm, -50mm, -0.05mm), x_size=90mm, y_size=100mm)
  Rectangle1.thicken(-0.07mm)
  EquationCurve1.thicken(0.01mm)
  Box1 [vacuum] = box(corner=(-160mm, -160mm, -80mm), size=(380mm, 400mm, 340mm))
  EquationCurve1.move(0mm, 0mm, -0.05mm)
  coordinate_system RelativeCS1 = origin=(38.571929mm, 0mm, -0.05mm) x=(1mm, 0mm, 0mm) y=(0mm, 1mm, 0mm)
  Cylinder1 [copper] = cylinder(axis=Z, base_centre=(-12mm, 0mm, 0.01mm), radius=0.40490195mm, height=0.3mm) in RelativeCS1
  Cylinder2 [copper] = cylinder(axis=Z, base_centre=(-0.64286549mm, 0mm, 0.01mm), radius=0.52683654mm, height=0.3mm) in RelativeCS1
  Rectangle2 = rectangle(corner=(-8mm, -0.5mm, 0.3mm), x_size=11mm, y_size=1mm) in RelativeCS1
  Rectangle2.move(0mm, 0mm, 0mm) in RelativeCS1
  Rectangle2.move(-0.11602895mm, 0mm, 0.01mm) in RelativeCS1
  Rectangle2.move(-4mm, 0mm, 0mm) in RelativeCS1
  Rectangle2.move(-1mm, 0mm, 0mm) in RelativeCS1
  Rectangle3 = rectangle(corner=(-8.6mm, 0.5mm, 0mm), x_size=-1.7mm, y_size=-1mm) in RelativeCS1
  Rectangle4 = rectangle(corner=(-12.3mm, -0.5mm, 0mm), x_size=1.1mm, y_size=1mm) in RelativeCS1
  Rectangle5 = rectangle(corner=(-11.2mm, 0.5mm, 0mm), x_size=0.9mm, y_size=-1mm) in RelativeCS1
  [Cylinder1, Cylinder2, Rectangle2, Rectangle3, Rectangle4].move(-6.2839711mm, 0mm, -0.01mm) in RelativeCS1
  Rectangle2.move(3mm, 0mm, 0mm) in RelativeCS1
  Rectangle3.move(1.3120417mm, 0mm, 0.02mm) in RelativeCS1
  Rectangle5.move(-5mm, 0mm, 0mm) in RelativeCS1
  Rectangle5.move(0.028070614mm, 0mm, 0.01mm) in RelativeCS1
  Rectangle4.move(1.2mm, 0mm, 0mm) in RelativeCS1
  Rectangle4.move(0.11204167mm, 0mm, 0.02mm) in RelativeCS1
  Rectangle2.move(-1mm, 0mm, 5.5511151e-17mm) in RelativeCS1
  Cylinder2.move(0mm, 0mm, 0.005mm) in RelativeCS1
  Cylinder2.move(0mm, 0mm, 0.005mm) in RelativeCS1
  Cylinder1.move(1.4790691mm, 0mm, 0mm) in RelativeCS1
boundaries and excitations:
  PerfE3: Perfect E Objects=Rectangle2
  PerfE4: Perfect E Objects=Rectangle3
  PerfE5: Perfect E Objects=Rectangle4
  Rad1: Radiation Objects=Box1
  1: Lumped Port Faces=Rectangle5.face(#315) Modes{Mode1{IntLine{middle of Rectangle5.edge(2 of 4) -> middle of Rectangle5.edge(4 of 4)} CharImp=Zpi}} Impedance=50ohm
setups:
  Setup1: HfssDriven Frequency=1GHz MaxDeltaS=0.02 MaximumPasses=15 MinimumPasses=1 MinimumConvergedPasses=1 PercentRefinement=30 BasisOrder=1 PortAccuracy=2
    sweep Sweep: 0.8GHz to 1.5GHz, 451 points; Type=Fast
source amplitudes:
  1:1: 1W 0deg
reports:
  S Parameter Plot 1: dB(S(1,1)) vs Freq on Setup1 : Sweep; markers m1 at 1.4613333GHz, m2 at 1.5146667GHz
